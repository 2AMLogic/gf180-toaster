* smoke-op @ tt_125c_3.63v -- GENERATED by sim/harness, do not edit
* corner=tt (typical NMOS / typical PMOS)
* temp=125.0 C  vdd=3.63 V  pdk=gf180mcuD@open_pdks f6eeac7dad085ffcc829ccfd721f7b4ce39edcf7

* ---- PVT parameters -------------------------------------------------
.param vdd_nom=3.3
.param vdd_val=3.63
.param temp_c=125.0

* ---- gf180 models -----------------------------------------------
.include "/home/ubuntu/.ciel/gf180mcuD/libs.tech/ngspice/design.ngspice"
.lib "/home/ubuntu/.ciel/gf180mcuD/libs.tech/ngspice/sm141064.ngspice" typical

.temp 125.0

* ---- testbench ------------------------------------------------------
.include "/home/ubuntu/GitHub/gf180-toaster/.loom/worktrees/issue-2/sim/smoke-op/corners/20261119-061333-c179898/frozen/smoke_op.spice"

* ---- measurement ----------------------------------------------------
.control
set numdgt=10
set noaskquit
  op
  let m_id_nfet_ua = i(vd)*1e6
  print m_id_nfet_ua
.endc
.end
